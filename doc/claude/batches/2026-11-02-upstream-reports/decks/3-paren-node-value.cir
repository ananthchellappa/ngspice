r3 is written from a(x), which manual 2.1.3.4 does not allow. Read as r3 a x 0 1k since 58e4cf26b. Before it, a dangling branch and i(v1) is 0
v1 x 0 1
r3 a(x) 0 1k
r4 a 0 1k
.control
op
print all
print @r3[resistance]
.endc
.end
