.dc @m1[w] across a bin edge: compare the 5u row with 4-dc-rebin-op.cir
.model nn.1 nmos level=14 version=4.8.2 lmin=1e-6 lmax=2e-6 wmin=1e-6 wmax=3e-6 vth0=0.4
.model nn.2 nmos level=14 version=4.8.2 lmin=1e-6 lmax=2e-6 wmin=3e-6 wmax=9e-6 vth0=0.7
vd d 0 1
vg g 0 1
m1 d g 0 0 nn w=2u l=1u
.control
dc @m1[w] 2u 5u 3u
print i(vd)
.endc
.end
