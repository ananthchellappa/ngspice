.dc @m1[w] with .option scale: the op after the sweep must equal the op before it
.option scale=1e-6
.model nn nmos level=1 vto=0.5 kp=1e-3
vd d 0 1
vg g 0 1
m1 d g 0 0 nn w=1 l=1
.control
set numdgt=6
op
print i(vd)
print @m1[w]
dc @m1[w] 1 3 1
print i(vd)
print @m1[w]
op
print i(vd)
.endc
.end
