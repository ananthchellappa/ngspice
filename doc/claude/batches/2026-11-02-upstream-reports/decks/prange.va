`include "disciplines.vams"
module prange(p,n);
 inout p,n; electrical p,n;
 parameter real R=1 from (0:inf);
 analog I(p,n) <+ V(p,n)/R;
endmodule
