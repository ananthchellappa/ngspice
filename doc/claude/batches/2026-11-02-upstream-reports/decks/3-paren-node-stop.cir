a node written net(0) on a source, which manual 2.1.3.4 does not allow
V1 net(0) 0 1
R1 net(0) 0 1k
.control
op
print all
.endc
.end
