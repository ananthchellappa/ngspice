meas sp ... when: exit 139, measure_when() reads v_realdata of a .sp scale
v1 in 0 dc 0 ac 1 portnum 1 z0 50 pwr 0 freq 1g
v2 out 0 dc 0 ac 0 portnum 2 z0 50 pwr 0 freq 1g
r1 in a 10
c1 a 0 1p
r2 a out 50
.sp lin 21 1g 5g
.control
run
meas sp x1 find vm(s_1_1) when vm(s_2_1)=0.5
echo survived
.endc
.end
