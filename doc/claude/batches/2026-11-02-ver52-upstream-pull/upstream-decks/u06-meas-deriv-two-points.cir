meas deriv on a 2-point sweep reads index -1: 0.475 and 0.525 where the slope is 0.5
v1 1 0 dc 1
v2 3 2 dc 1
r1 1 2 1k
r2 3 0 1k
.control
dc v1 10 20 10
print v(2)
meas dc d1 deriv v(2) at=10
meas dc d2 deriv v(2) at=15
meas dc d3 deriv v(2) at=20
.endc
.end
