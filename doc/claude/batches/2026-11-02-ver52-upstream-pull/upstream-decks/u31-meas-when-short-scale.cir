meas when loops by the vector's length, not the scale's: run under valgrind. a is longer than the 3-point scale.
v1 1 0 dc 1
r1 1 0 1k
.dc v1 1 3 1
.control
run
let a = vector(5000)
meas dc w1 when a=2500
meas dc w2 find a when a=2500
echo survived
.endc
.end
