af240ba02: .dc @m1[w] applies scale again on restore. Second op must equal the first.
.option scale=1e-6
.model nn nmos level=1 vto=0.5 kp=1e-3
vd d 0 1
vg g 0 1
m1 d g 0 0 nn w=1 l=1
.control
set numdgt=9
op
print i(vd)
dc @m1[w] 1 3 1
op
print i(vd)
.endc
.end
