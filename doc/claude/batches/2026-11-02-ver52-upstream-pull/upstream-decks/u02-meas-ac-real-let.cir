meas ac avg of a real let vector with a window
v1 in 0 dc 0 ac 1
r1 in out 1k
c1 out 0 1u
.ac lin 21 100 500
.control
run
let y = frequency
let y = real(y)
meas ac x1 avg y from=130 to=410
echo survived
.endc
.end
