meas dc deriv ... when, on an AC plot: exit 139 since deriv reached com_measure_when(). 45.2 answers "not supported".
v3 4 0 dc 0 ac 1
r3 4 5 1k
c3 5 0 1u
.ac dec 1 10 100
.control
run
let ry=real(v(5))
meas dc w1 deriv ry when ry=0.5
echo survived
.endc
.end
