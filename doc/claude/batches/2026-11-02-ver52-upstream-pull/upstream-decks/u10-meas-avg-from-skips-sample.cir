avg with from= (ac) and integ with from= (dc, ac) drop the first sample inside the window. True over [1.3,1.7]: avg 0.4375, integ 0.175
v1 1 0 dc 0 ac 1
r1 1 0 1
.control
dc v1 1 2 0.2
let y = 0*v(1)
let y[2] = 1
meas dc a1 avg y from=1.3 to=1.7
meas dc i1 integ y from=1.3 to=1.7
ac lin 6 1 2
let y = 0*v(1)
let y[2] = 1
meas ac a2 avg y from=1.3 to=1.7
meas ac i2 integ y from=1.3 to=1.7
.endc
.end
