meas sp ... trig/targ: exit 139
v1 in 0 dc 0 ac 1 portnum 1 z0 50 pwr 0 freq 1g
v2 out 0 dc 0 ac 0 portnum 2 z0 50 pwr 0 freq 1g
r1 in a 10
c1 a 0 1p
r2 a out 50
.sp lin 21 1g 5g
.control
run
meas sp x1 trig vm(s_2_1) val=0.5 fall=1 targ vm(s_1_1) val=0.5 rise=1
echo survived
.endc
.end
