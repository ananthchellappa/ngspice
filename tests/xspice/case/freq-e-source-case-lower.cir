* lower case twin of freq-e-source-case.cir
v1 1 0 dc 0 ac 1
r1 1 0 1k
e1 2 0 freq {v(1)} = db
+ (1, 0, 0)
+ (1000, 0, 0)
r2 2 0 1k
.OPTIONS noacct
.control
ac lin 1 100 100
print vm(2)
.endc
.end
