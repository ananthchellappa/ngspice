* mixed-type node whose two spellings differ only in case, under casemode=preserve
* Phase 3 gate 2.  Under 'preserve' two spellings are one identifier, so the
* digital node 'A' written by the d_buffer card and the analog node 'a' written
* by R1 are ONE net, and it is a mixed-type net: the auto-bridge must insert a
* dac_bridge onto it.
*   src/xspice/evt/evtcheck_nodes.c:720, at feff44746
*     if (strcmp(event_node->name, analog_node->name) == 0)
* compared the event-side spelling against the analog-side spelling with
* strcmp, so under 'preserve' the two never matched, no bridge card was
* generated, and the analog net was left driven by nothing but R1 to ground.
* Gate 4 must land first: the generated bridge card carries the ANALOG
* spelling in both port lists (flush_card feeds one buffer into both %s), so
* its digital port re-enters the interner, and with that still strcmp it would
* mint a third event node and the bridge would land on nothing.
* RED evidence at feff44746: this deck prints v(a) = 0.000000e+00 while
* auto-bridge-node-case-lower.cir, which is the same circuit with both
* spellings lower case, prints 3.300000e+00.  Under the default 'fold' mode the
* reader lower cases both spellings, so this deck already printed 3.3 there;
* the defect is 'preserve'-only.
* The assertion is on the analog side deliberately.  Event nodes print through
* 'eprint', which is src/xspice/evt/evtprint.c:341 - one of the sites this
* change edits - and a deck must not assert on a site its own commit moves.
V1 in 0 dc 1
R0 in 0 1meg
A1 [in] [Dig] adc1
.model adc1 adc_bridge(in_low=0.4 in_high=0.6)
A2 Dig A dbuf
.model dbuf d_buffer
R1 a 0 1k
.OPTIONS noacct
.control
op
print v(a)
.endc
.end
