* an X card spelled x1, under casemode=distinguish
* The control for auto-bridge-vcc-subckt-case.cir: the same circuit with the
* subcircuit instance spelled x1, which is the spelling numparam stores
* whatever the deck wrote.  It printed 6.000000e+00 before the
* doc/codex/issues/0029 defect (a) change and after it, in all three modes,
* and it is what pins the device letter as the whole of the difference - the
* subcircuit formal is still spelled VCC here, as in the upper-case deck.
.subckt buf1 din aout VCC=6
A2 din aout dbuf
.model dbuf d_buffer
.ends
V1 in 0 dc 1
R0 in 0 1meg
A1 [in] [dig] adc1
.model adc1 adc_bridge(in_low=0.4 in_high=0.6)
x1 dig outn buf1
R1 outn 0 1k
.OPTIONS noacct
.control
op
print v(outn)
.endc
.end
