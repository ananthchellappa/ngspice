* an X card spelled x1, under casemode=distinguish
* The control for auto-bridge-vcc-subckt-case.cir: the same circuit with the
* subcircuit instance spelled x1, which is the spelling numparam stores
* whatever the deck wrote.
* It is a control on the instance name only, and NOT a deck that held
* constant across the doc/codex/issues/0029 defect (a) change.  Its formal is
* still spelled VCC, so before that change it missed on the final component's
* case exactly as its upper-case sibling did: measured at 3dbd6ba95,
* 3.300000e+00 under 'distinguish' against 6.000000e+00 under 'fold' and
* 'preserve'.  What it isolates is that the instance name was a *second*,
* independent reason for the miss, since it is the only thing that differs
* between the two decks and the sibling still failed when this one was made
* to pass.  Both print 6.000000e+00 in all three modes now.
.subckt buf1 din aout VCC=6
A2 din aout dbuf
.model dbuf d_buffer
.ends
V1 in 0 dc 1
R0 in 0 1meg
A1 [in] [dig] adc1
.model adc1 adc_bridge(in_low=0.4 in_high=0.6)
x1 dig outn buf1
R1 outn 0 1k
.OPTIONS noacct
.control
op
print v(outn)
.endc
.end
