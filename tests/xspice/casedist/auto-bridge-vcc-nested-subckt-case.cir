* a nested subcircuit's vcc, under casemode=distinguish
* The guard for the device-letter fold of doc/codex/issues/0029 defect (a).
* numparam forces ONE character of the instance path to lower case - the
* first, at src/frontend/numparam/spicenum.c:721, `*inst_name = 'x'` - so a
* nested instance is stored as 'x1.XIn.vcc': index 0 folded, the inner
* component left exactly as the deck wrote it.
* fold_path_device_letter() (src/xspice/evt/evtcheck_nodes.c) therefore folds
* the first character of the whole path and no more.  An earlier draft folded
* the first character of every dot-separated component, which is a different
* rule from the one numparam applies: it built the probe 'x1.xIn.vcc' against
* the key 'x1.XIn.vcc' and broke this deck, which had worked under
* 'distinguish' since before any of this work.  Measured on that draft:
* 3.300000e+00 here against 6.000000e+00 under 'fold' and 'preserve'.
* This deck prints 6.000000e+00 in all three modes, before and after the
* whole of 0029, and its job is to keep it that way.
.subckt outer din aout
XIn din aout inner
.ends
.subckt inner din aout vcc=6
A2 din aout dbuf
.model dbuf d_buffer
.ends
V1 in 0 dc 1
R0 in 0 1meg
A1 [in] [dig] adc1
.model adc1 adc_bridge(in_low=0.4 in_high=0.6)
x1 dig outn outer
R1 outn 0 1k
.OPTIONS noacct
.control
op
print v(outn)
.endc
.end
