* two event-node spellings are one event node in the default fold mode
* The fold half of the pair tests/xspice/case/event-node-case.cir (preserve)
* and tests/xspice/casedist/event-node-case-split.cir (distinguish).  The
* reader lowercases every card here, so the adc_bridge's 'Dig' and the
* d_buffer's 'dig' arrive at the interner as one spelling, the node is driven,
* and v(aout) = 5.0 as in preserve.
* Its job is the near-miss diagnostic added for doc/codex/issues/0030.  That
* diagnostic is guarded on casemode == distinguish, not on the spellings in
* the deck, and this deck holds the spellings constant while changing only the
* mode: EVTnode_case_check() must stay silent here, because after folding
* there is no undriven node and no case variant to name, and the number must
* not move.  Verified by hand: stderr is empty for this deck.
* check.sh's filter drops every line containing 'Warning' from both sides, so
* the silence cannot be asserted here and the assertion is the number.
V1 in 0 dc 1
R0 in 0 1meg
A1 [in] [Dig] adc1
.model adc1 adc_bridge(in_low=0.4 in_high=0.6)
A2 dig outq dbuf
.model dbuf d_buffer
A3 [outq] [aout] dac1
.model dac1 dac_bridge(out_low=0.0 out_high=5.0 out_undef=2.5)
R1 aout 0 1k
.OPTIONS noacct
.control
op
print v(aout)
.endc
.end
