* .probe under casemode=distinguish: terminal currents inside an instance
*
* VDD 2 V, X1 an instance of AMP (R1 500 from P to Mid, R2 500 from Mid
* to O), RL 10k from OUT to ground: v(OUT) = 20/11 V and 2/11 mA flow
* through X1.
*
* Under distinguish two spellings of a name are two names. X1.R1 and X1,O
* are the resistor and the port of the deck: X1.R1#branch, X1:O#branch.
* x1.r2,2 and x1,o name an instance x1, which the deck does not have: they
* are refused, and the reason names the spelling the deck has.
VDD vdd 0 dc 2
X1 vdd OUT AMP
RL OUT 0 10k
.subckt AMP P O
R1 P Mid 500
R2 Mid O 500
.ends
.probe I(X1.R1) I(x1.r2,2) I(X1,O) I(x1,o)
.control
op
print all
let k = 0
let k = (abs(i(X1.R1) - (2 - v(OUT))/1k) < 1e-15) & (abs(i(X1:O) + v(OUT)/10k) < 1e-15)
if k
  echo probechk case-distinguish pass
else
  echo probechk case-distinguish fail
end
.endc
.end
