* probe: a terminal that is also the probe of the stb analysis
*
* The stb analysis puts its own 0 V source on a terminal it is given,
* x positive. A .probe of the same terminal gets a source of its own in
* series, with the sign of a current into the terminal; the circuit is
* the same and each source has the same current, with its own sign.
*   x1.r1:1 / x1.r1,1   an element inside an instance
*   x1:o / x1,o         a port of an instance
vdd vdd 0 dc 2
x1 vdd out amp
rl out 0 10k
.subckt amp p o
r1 p o 1k
.ends
.probe I(x1.r1,1) I(x1,o)
.control
if 0
  stb x1.r1:1 dec 10 1 1e6
  stb x1:o dec 10 1 1e6
end
op
let k = 0
let k = (abs(v(out) - 20/11) < 1e-9)
if k
  echo probechk stb-shared-circuit-unchanged pass
else
  echo probechk stb-shared-circuit-unchanged fail
end
let k = 0
let k = (abs(i(x1.r1:n1) - (2 - v(out))/1k) < 1e-12) & (abs(v.r.x1.r1#stb1#branch + i(x1.r1:n1)) < 1e-15)
if k
  echo probechk stb-shared-element pass
else
  echo probechk stb-shared-element fail
end
let k = 0
let k = (abs(i(x1:o) + v(out)/10k) < 1e-12) & (abs(v.x1#stb2#branch + i(x1:o)) < 1e-15)
if k
  echo probechk stb-shared-port pass
else
  echo probechk stb-shared-port fail
end
.endc
.end
