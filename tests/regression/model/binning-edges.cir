check the MOS bin limits: min <= size < max, except that the outermost max is legal

* showmod names the bin. The cards sit inside the subcircuit, as a PDK's do,
* because under hsa subckt.c prunes the bins of a literal size before binning.
*
* The rule is half open, so a size on an inner edge belongs to the upper bin
* and a size on the top edge of the table would have no bin at all. That top
* edge is legal, it is what the PDK's own lmax and wmax say.
*
* w=15 nf=5 and the like are one finger of exactly 3 um, an inner edge. In
* single precision scale*w/nf comes out one step under the card's wmin. w=2.1
* nf=5 is the same thing on the bottom edge of the table.
*
* l=1 w=1010 and l=20.2 w=3 are on the top edge in one axis and on an inner edge
* in the other. The inner edge still goes to the upper bin.
*
* The cards are in sky130's order, highest first: binning searches the last
* parsed first, so this order is the one that finds the lower card first.
*
* Each size is a circuit of its own: a size with no bin stops the load. The
* last two sizes are outside the table, so they want no card at all (card.0).

.control
set llist = ( 0.5 1   0.5 20.2 0.5  20.2 0.15 0.5 0.5 0.5 1    20.2 25 20.2005 )
set wlist = ( 1   1   3   1    1010 1010 0.42 15  21  2.1 1010 3    1  1       )
set nlist = ( 1   1   1   1    1    1    1    5   7   5   1    1    1  1       )
set blist = ( 1   3   2   3    2    4    1    2   2   1   4    4    0  0       )

foreach mode 1 2 3
  * 1 no compatibility mode, 2 hsa with a literal size, 3 hsa with an expression
  if $mode = 1
    unset ngbehavior
  else
    set ngbehavior=hsa
  end
  let ix = 0
  while ix < 14
    let ix = ix + 1
    set c = "$&ix"
    set ll = $llist[$c]
    set ww = $wlist[$c]
    set nn = $nlist[$c]
    set want = $blist[$c]
    circbyline * binning $mode $c
    circbyline .option scale=1u
    circbyline .subckt dut d g s b
    circbyline .param l=1 w=1 nf=1
    circbyline mn d g s b card l=\{l\} w=\{w\} nf=\{nf\}
    circbyline .model card.4 nmos level=54 version=4.5 lmin=1e-6 lmax=2.02e-5 wmin=3e-6 wmax=1.01e-3
    circbyline .model card.3 nmos level=54 version=4.5 lmin=1e-6 lmax=2.02e-5 wmin=4.2e-7 wmax=3e-6
    circbyline .model card.2 nmos level=54 version=4.5 lmin=1.5e-7 lmax=1e-6 wmin=3e-6 wmax=1.01e-3
    circbyline .model card.1 nmos level=54 version=4.5 lmin=1.5e-7 lmax=1e-6 wmin=4.2e-7 wmax=3e-6
    circbyline .ends dut
    circbyline vd d 0 0.9
    circbyline vg g 0 0.9
    if $mode = 3
      circbyline .param pl=$ll pw=$ww pn=$nn
      circbyline x1 d g 0 0 dut l=\{pl\} w=\{pw\} nf=\{pn\}
    else
      circbyline x1 d g 0 0 dut l=$ll w=$ww nf=$nn
    end
    circbyline .end
    op
    echo mode $mode l=$ll w=$ww nf=$nn wanted card.$want
    showmod m.x1.mn : model
    destroy all
    remcirc
  end
end
.endc

.end
