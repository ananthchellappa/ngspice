* stb: an .ic on the net of a probed terminal, option klu
*
* Three loops of the same values, each with an .ic of 0.5 V on its
* feedback net:
*   a  the probe is terminal 4 of g1, a controlling input
*   b  the probe is the port inn of the instance x2, which leads to the
*      controlling input of the element inside
*   c  no probe
* The reader repeats the .ic of the net for the new node of a probe. With
* option klu an .ic needs an element of the matrix on the diagonal of its
* node, and a controlling input makes none: the reader adds a capacitor
* of 0 F from the new node to ground with the repeated .ic. Without it
* every analysis of the deck would stop when the initial conditions are
* set.
*
* In each loop n = 100 (in - fb) and out = n, with rf from out to fb and
* cf on fb:
*   op:        no current in rf, fb = out = 100/101 V
*   tran:      starts from fb = 0.5 V, which the .ic holds
*   tran uic:  starts with 0.5 V on cf and 0 V on c1
*   loopgain = -100 / ((1 + j w 100k 1n) (1 + j w 1k 1u))
* Which solver ran is not asserted here: the lines that name it are not
* compared by the check. (noinit: no table of the initial solution.)
.option klu
.option noinit
.subckt amp inp inn out
g1 0 out inp inn 1m
.ends
vina ina 0 dc 1
g1 0 na ina fba 1m
r1a na 0 100k
c1a na 0 1n
e1a outa 0 na 0 1
rfa outa fba 1k
cfa fba 0 1u
vinb inb 0 dc 1
x2 inb fbb nb amp
r1b nb 0 100k
c1b nb 0 1n
e1b outb 0 nb 0 1
rfb outb fbb 1k
cfb fbb 0 1u
vinc inc 0 dc 1
g1c 0 nc inc fbc 1m
r1c nc 0 100k
c1c nc 0 1n
e1c outc 0 nc 0 1
rfc outc fbc 1k
cfc fbc 0 1u
.ic v(fba)=0.5 v(fbb)=0.5 v(fbc)=0.5
.control
op
let k = 0
let k = (abs(v(outa) - 100/101) < 1e-9) & (abs(v(outb) - 100/101) < 1e-9) & (abs(v(outc) - 100/101) < 1e-9)
if k
  echo stbchk uic-klu-op pass
else
  echo stbchk uic-klu-op fail
end

tran 1u 100u
let k = 0
let k = (abs(v(fbc)[0] - 0.5) < 1e-6) & (vecmax(abs(v(fba) - v(fbc))) < 1e-9) & (vecmax(abs(v(fbb) - v(fbc))) < 1e-9)
if k
  echo stbchk uic-klu-tran-holds-ic pass
else
  echo stbchk uic-klu-tran-holds-ic fail
end
let k = 0
let k = (vecmax(abs(v(g1#stb4) - v(fba))) < 1e-9) & (vecmax(abs(v(x2#stb2) - v(fbb))) < 1e-9)
if k
  echo stbchk uic-klu-new-nodes-follow pass
else
  echo stbchk uic-klu-new-nodes-follow fail
end

tran 1u 100u uic
let k = 0
let k = (abs(v(fbc)[0] - 0.5) < 1e-3) & (vecmax(abs(v(fba) - v(fbc))) < 1e-9) & (vecmax(abs(v(fbb) - v(fbc))) < 1e-9)
if k
  echo stbchk uic-klu-uic-same-as-unprobed pass
else
  echo stbchk uic-klu-uic-same-as-unprobed fail
end

stb g1:4 dec 10 1 1e6 > term-uic-klu.stblog
let k = 0
let k = (length(loopgain) eq 61) & (vecmax(abs(loopgain + 100/((1 + j(2*pi*real(frequency)*100k*1n))*(1 + j(2*pi*real(frequency)*1k*1u))))/abs(loopgain)) < 1e-9)
if k
  echo stbchk uic-klu-loopgain-element pass
else
  echo stbchk uic-klu-loopgain-element fail
end

stb x2:inn dec 10 1 1e6 > term-uic-klu.stblog
let k = 0
let k = (length(loopgain) eq 61) & (vecmax(abs(loopgain + 100/((1 + j(2*pi*real(frequency)*100k*1n))*(1 + j(2*pi*real(frequency)*1k*1u))))/abs(loopgain)) < 1e-9)
if k
  echo stbchk uic-klu-loopgain-port pass
else
  echo stbchk uic-klu-loopgain-port fail
end
.endc
.end
