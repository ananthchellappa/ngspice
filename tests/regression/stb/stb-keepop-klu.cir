* stb: the option keepopinfo, with the KLU solver
*
* The deck stb-keepop.cir, solved with the option klu. The operating
* point is solved again at each frequency, and the matrix goes from its
* real form to the complex one and back each time; the operating point
* plot still holds the one found before the sweep.
*
* The loop: vtest carries -12 V and btest = -a v(west)^2 - k h, with
* h = hertz/1k, a = 1 + h and k = v(kest), so
*     a v(west)^2 + v(west) + k h - 12 = 0.
* With k = 0:  loopgain = 1 - sqrt(49 + 48 f/1k), and before the sweep
* (hertz is 0) v(west) = 3, v(nest) = v(oest) = -9, no current. With
* k = 13 there is no solution from h = 0.93 on: a sweep from 100 Hz to
* 10 kHz fails at 1 kHz, and no plot is made.
*
* The comparison with the operating point plot of an ac analysis is in
* stb-keepop.cir only: with this solver the ac analysis itself does not
* get through a circuit whose sources depend on hertz.
*
* (The names contain "est" on purpose, see stb-keepop.cir.)
.option klu
.options keepopinfo
.options reltol=1e-9 vntol=1e-12 abstol=1e-15
vtest nest west dc -12
btest oest 0 v = -v(west)*v(west)*(1 + hertz/1k) - v(kest)*hertz/1k
rest oest nest 1k
vkest kest 0 dc 0
.control
set nbefore = $#plots
set cbefore = $curplot

stb vtest dec 5 100 1e4 > stb-keepop-klu.stblog
set sp = $curplot
set mp = none
if $?stb_marginplot
  set mp = $stb_marginplot
end

* three plots, in this order: op, stb, stbmargin
set ops = none
set seen = ""
let const.nseen = 0
foreach pl $plots
  let const.nseen = const.nseen + 1
  if const.nseen > $nbefore
    strstr p1 "$pl" "op"
    if $p1 eq 0
      set ops = $pl
      set seen = "$seen op"
    end
    strstr p1 "$pl" "stb"
    strstr p2 "$pl" "stbmargin"
    if ($p1 eq 0) & ($p2 < 0)
      set seen = "$seen stb"
    end
    if $p2 eq 0
      set seen = "$seen stbmargin"
    end
  end
end
strcmp order "$seen" " op stb stbmargin"
if ($#plots eq $nbefore + 3) & ($order eq 0)
  echo stbchk keepop-klu-three-plots pass
else
  echo stbchk keepop-klu-three-plots fail
end

* the loop-gain plot is the current one, and it holds the loop gain
strstr p1 "$sp" "stb"
strstr p2 "$sp" "stbmargin"
strstr p3 "$mp" "stbmargin"
let k = 0
let k = (length(loopgain) eq 11) & (vecmax(abs(loopgain - 1 + sqrt(49 + 48*real(frequency)/1k))/sqrt(49 + 48*real(frequency)/1k)) < 1e-9)
if k & ($p1 eq 0) & ($p2 < 0) & ($p3 eq 0)
  echo stbchk keepop-klu-loopgain-plot pass
else
  echo stbchk keepop-klu-loopgain-plot fail
end

* the operating point before the sweep, not the last one of the sweep
let k = 0
let k = (length({$ops}.west) eq 1) & (abs({$ops}.west - 3) < 1e-6) & (abs({$ops}.nest + 9) < 1e-6) & (abs({$ops}.oest + 9) < 1e-6) & (abs({$ops}.vtest#branch) < 1e-9)
if k
  echo stbchk keepop-klu-values pass
else
  echo stbchk keepop-klu-values fail
end

* a run that fails during the sweep: the line, and no plot
alter vkest dc = 13
set nmid = $#plots
set sim_status = 0
stb vtest dec 5 100 1e4 >& stb-keepop-klu.stberr
let const.nerr = 0
set n1 = 1
fopen f1 stb-keepop-klu.stberr r
while $n1 >= 0
  set ln = "none"
  fread ln $f1 n1
  strstr p1 "_$ln" "Error: stb: probe vtest: the operating point did not converge"
  if $p1 >= 0
    let const.nerr = const.nerr + 1
  end
end
fclose $f1
strcmp same "$curplot" "$sp"
set msame = 1
if $?stb_marginplot
  strcmp msame "$stb_marginplot" "$mp"
end
if (const.nerr eq 1) & ($sim_status eq 1) & ($#plots eq $nmid) & ($same eq 0) & ($msame eq 0)
  echo stbchk keepop-klu-failing-run-no-plot pass
else
  echo stbchk keepop-klu-failing-run-no-plot fail
end
set sim_status = 0

* the circuit loaded again: three plots again, and hertz is 0 again before
* the sweep
reset
set nmid = $#plots
stb vtest dec 5 100 1e4 > stb-keepop-klu.stblog
set opb = none
let const.nseen = 0
foreach pl $plots
  let const.nseen = const.nseen + 1
  if const.nseen > $nmid
    strstr p1 "$pl" "op"
    if $p1 eq 0
      set opb = $pl
    end
  end
end
strstr p1 "$curplot" "stb"
strcmp same "$curplot" "$sp"
strcmp osame "$opb" "$ops"
let k = 0
let k = (length(loopgain) eq 11) & (vecmax(abs(loopgain - 1 + sqrt(49 + 48*real(frequency)/1k))/sqrt(49 + 48*real(frequency)/1k)) < 1e-9) & (abs({$opb}.west - 3) < 1e-6) & (abs({$opb}.nest + 9) < 1e-6)
if k & ($#plots eq $nmid + 3) & ($p1 eq 0) & ($same ne 0) & ($osame ne 0)
  echo stbchk keepop-klu-again pass
else
  echo stbchk keepop-klu-again fail
end
.endc
.end
