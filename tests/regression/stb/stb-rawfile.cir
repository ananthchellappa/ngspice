* stb: the two plots in a raw file, and the types of their vectors
*
* The loop of stb-flat.cir: loopgain = -10 / (1 + j f/fp), fp = 1/(2 pi r1 c1).
*
* The loop gain and the margins are computed results, not node voltages:
* their vectors have no type. In a plot they are listed as "notype", and a
* raw file names them "loopgain", "phasemargin" and so on, not
* "v(loopgain)". The two frequencies of the margins, "phasemarginfreq" and
* "gainmarginfreq", are of the type frequency.
*
* "run <file>" writes the plot "STB Analysis" and then the plot "STB
* Margins" to the file and makes no plot in memory. The file is read line
* by line here, and then loaded: it gives two more plots, and the loop gain
* in it is the one of a run in memory. The frequency in the file has no
* imaginary part. (The file is written in ASCII, with 16 digits.)
vprb x y dc 0
e1 out 0 0 y 10
r1 out x 1k
c1 x 0 1u
.stb vprb dec 5 1 1e6
.control
let const.fp = 1/(2*pi*1k*1u)
set filetype = ascii

* a run in memory: the types in the two plots
stb vprb dec 5 1 1e6 > stb-rawfile.stblog
set sp = $curplot
set mp = none
if $?stb_marginplot
  set mp = $stb_marginplot
end
display > stb-rawfile.stblog
let const.ngain = 0
set n1 = 1
fopen f1 stb-rawfile.stblog r
while $n1 >= 0
  set ln = "none"
  fread ln $f1 n1
  strstr p1 "_$ln" " loopgain "
  strstr p2 "_$ln" ": notype, complex, 31 long"
  if ($p1 >= 0) & ($p2 >= 0)
    let const.ngain = const.ngain + 1
  end
end
fclose $f1
strstr pos "$sp" "stb"
if (const.ngain eq 1) & ($pos eq 0)
  echo stbchk rawfile-type-in-plot pass
else
  echo stbchk rawfile-type-in-plot fail
end

setplot $mp
display > stb-rawfile.stblog
let const.nmargin = 0
let const.nmfreq = 0
set n1 = 1
fopen f1 stb-rawfile.stblog r
while $n1 >= 0
  set ln = "none"
  fread ln $f1 n1
  strstr p1 "_$ln" "margin "
  strstr p2 "_$ln" ": notype, real, 1 long"
  if ($p1 >= 0) & ($p2 >= 0)
    let const.nmargin = const.nmargin + 1
  end
  strstr p1 "_$ln" "marginfreq "
  strstr p2 "_$ln" ": frequency, real, 1 long"
  if ($p1 >= 0) & ($p2 >= 0)
    let const.nmfreq = const.nmfreq + 1
  end
end
fclose $f1
strstr pos "$mp" "stbmargin"
if (const.nmargin eq 2) & (const.nmfreq eq 2) & ($pos eq 0)
  echo stbchk rawfile-type-in-margins-plot pass
else
  echo stbchk rawfile-type-in-margins-plot fail
end
setplot $sp

* the run of the .stb card, into a file: no plot is made
set nbefore = $#plots
run stb-rawfile.raw > stb-rawfile.stblog
strcmp same "$curplot" "$sp"
if ($#plots eq $nbefore) & ($same eq 0) & ($?stb_marginplot eq 0)
  echo stbchk rawfile-no-plot pass
else
  echo stbchk rawfile-no-plot fail
end

* the file: the loop-gain plot comes first, then the margins plot; six
* vectors, none of them written as a voltage, the two frequencies of the
* margins of the type frequency
let const.nplot = 0
let const.nstb = 0
let const.nmarg = 0
let const.first = 0
let const.nfreq = 0
let const.ngain = 0
let const.nmargin = 0
let const.nmfreq = 0
let const.nvolt = 0
set n1 = 1
fopen f1 stb-rawfile.raw r
while $n1 >= 0
  set ln = "none"
  fread ln $f1 n1
  strstr p1 "_$ln" "_Plotname: "
  if $p1 eq 0
    let const.nplot = const.nplot + 1
  end
  strstr p1 "_$ln" "_Plotname: STB Analysis"
  if $p1 eq 0
    let const.nstb = const.nstb + 1
    if const.nmarg eq 0
      let const.first = 1
    end
  end
  strstr p1 "_$ln" "_Plotname: STB Margins"
  if $p1 eq 0
    let const.nmarg = const.nmarg + 1
  end
  strstr p1 "_$ln" "frequency"
  strstr p2 "_$ln" "grid=3"
  if ($p1 >= 0) & ($p2 >= 0)
    let const.nfreq = const.nfreq + 1
  end
  strstr p1 "_$ln" "loopgain"
  strstr p2 "_$ln" "notype"
  if ($p1 >= 0) & ($p2 >= 0)
    let const.ngain = const.ngain + 1
  end
  strstr p1 "_$ln" "margin"
  strstr p2 "_$ln" "notype"
  strstr p3 "_$ln" "marginfreq"
  if ($p1 >= 0) & ($p2 >= 0) & ($p3 < 0)
    let const.nmargin = const.nmargin + 1
  end
  strstr p2 "_$ln" "frequency"
  if ($p3 >= 0) & ($p2 >= 0)
    let const.nmfreq = const.nmfreq + 1
  end
  strstr p1 "_$ln" "v("
  if $p1 >= 0
    let const.nvolt = const.nvolt + 1
  end
  strstr p1 "_$ln" "voltage"
  if $p1 >= 0
    let const.nvolt = const.nvolt + 1
  end
end
fclose $f1
if (const.nplot eq 2) & (const.nstb eq 1) & (const.nmarg eq 1) & (const.first eq 1)
  echo stbchk rawfile-two-plots pass
else
  echo stbchk rawfile-two-plots fail
end
if (const.nfreq eq 1) & (const.ngain eq 1) & (const.nmargin eq 2) & (const.nmfreq eq 2) & (const.nvolt eq 0)
  echo stbchk rawfile-vector-names pass
else
  echo stbchk rawfile-vector-names fail
end

* the file loaded: two more plots, a loop-gain plot and a margins plot
load stb-rawfile.raw > stb-rawfile.stblog
set lp = none
set lm = none
let const.nseen = 0
foreach pl $plots
  let const.nseen = const.nseen + 1
  if const.nseen > $nbefore
    strstr p1 "$pl" "stb"
    strstr p2 "$pl" "stbmargin"
    if ($p1 eq 0) & ($p2 < 0)
      set lp = $pl
    end
    if $p2 eq 0
      set lm = $pl
    end
  end
end
strcmp nolp "$lp" "none"
strcmp nolm "$lm" "none"
if ($#plots eq $nbefore + 2) & ($nolp ne 0) & ($nolm ne 0)
  echo stbchk rawfile-loaded-plots pass
else
  echo stbchk rawfile-loaded-plots fail
end

* the loop gain of the file: that of the run in memory, and the closed form
setplot $lp
let k = 0
let k = (length(loopgain) eq 31) & (vecmax(abs(loopgain - {$sp}.loopgain)) < 1e-12) & (vecmax(abs(loopgain + 10/(1 + j(real(frequency)/const.fp)))) < 1e-9)
if k & ($nolp ne 0)
  echo stbchk rawfile-loaded-loopgain pass
else
  echo stbchk rawfile-loaded-loopgain fail
end
let k = 0
let k = (length(frequency) eq 31) & (vecmax(abs(imag(frequency))) eq 0) & (vecmax(abs(real(frequency)/real({$sp}.frequency) - 1)) < 1e-14)
if k & ($nolp ne 0)
  echo stbchk rawfile-loaded-frequency pass
else
  echo stbchk rawfile-loaded-frequency fail
end

* the margins of the file: those of the run in memory (there is no gain
* margin: NaN in both)
setplot $lm
let k = 0
let k = (length(phasemargin) eq 1) & (abs(phasemargin - {$mp}.phasemargin) < 1e-12) & (abs(phasemarginfreq - {$mp}.phasemarginfreq) < 1e-9) & ((gainmargin eq gainmargin) eq 0) & ((gainmarginfreq eq gainmarginfreq) eq 0)
if k & ($nolm ne 0)
  echo stbchk rawfile-loaded-margins pass
else
  echo stbchk rawfile-loaded-margins fail
end
setplot $sp
.endc
.end
