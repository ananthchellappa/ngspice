* stb: a comment of the user is never taken for a collected probe
*
* The probes collected from the .control section are kept with the
* stored deck as cards that look like comments. A comment of the same
* text written by the user (here directly after .endc, where the stored
* deck keeps it) declares nothing, neither when the deck is read nor
* after reset: nothing is inserted at r1:1. The probe r2:1, declared in
* the .control section, is inserted both times.
v1 a 0 dc 1
r1 a b 1k
r2 b 0 1k
.control
if 0
  stb r2:1 dec 10 1 1e6
end
op
print all
let k = 0
let k = (abs(v(r2#stb1) - v(b)) < 1e-12) & (abs(v.r2#stb1#branch + 0.5m) < 1e-12)
let k1 = 1
let k1 = 0 * length(v(r1#stb1))
if k & k1
  echo stbchk forged-first-load pass
else
  echo stbchk forged-first-load fail
end
reset
op
print all
let k = 0
let k = (abs(v(r2#stb1) - v(b)) < 1e-12) & (abs(v.r2#stb1#branch + 0.5m) < 1e-12)
let k1 = 1
let k1 = 0 * length(v(r1#stb1))
if k & k1
  echo stbchk forged-after-reset pass
else
  echo stbchk forged-after-reset fail
end
.endc
*stb-probe r1:1
.end
