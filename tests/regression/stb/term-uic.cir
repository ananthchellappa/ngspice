* stb: an initial condition on the net also holds for the probed terminal
*
* Two equal RC pairs with .ic 1 V, run with uic; the capacitor of the
* first has its terminal 1 probed. The inserted source has no state, so
* without more the new node would start at 0 V and pull the net down in
* the first step. The reader repeats the .ic of the net for the new node:
* the two pairs give the same curve, which starts at 1 V (its first
* point is 0.99999 V) and is at
* exp(-0.1) = 0.9048 V after 100 us.
r1 y 0 1k
c1 y 0 1u
r2 y2 0 1k
c2 y2 0 1u
.ic v(y)=1 v(y2)=1
.control
if 0
  stb c1:1 dec 10 1 1e6
end
tran 10u 100u uic
let k = 0
let k = (vecmax(abs(v(y) - v(y2))) < 1e-12) & (abs(v(y)[0] - 1) < 1e-4) & (v(y)[length(v(y)) - 1] > 0.9) & (v(y)[length(v(y)) - 1] < 0.91)
if k
  echo stbchk uic-same-as-unprobed pass
else
  echo stbchk uic-same-as-unprobed fail
end
let k = 0
let k = vecmax(abs(v(c1#stb1) - v(y))) < 1e-12
if k
  echo stbchk uic-new-node-follows pass
else
  echo stbchk uic-new-node-follows fail
end
.endc
.end
