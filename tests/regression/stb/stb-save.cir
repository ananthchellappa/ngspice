* stb: save and .save do not strip the loop-gain plot
*
* The loop of stb-flat.cir with a .save card. The loop gain is a computed
* result, not a node of the circuit: the stb plot keeps "frequency" and
* "loopgain", at full length, whatever is saved. An ac analysis obeys the
* saves as before.
vprb x y dc 0
e1 out 0 0 y 10
r1 out x 1k
c1 x 0 1u
.save v(out)
.control
let const.fp = 1/(2*pi*1k*1u)

stb vprb dec 5 1 1e6 > stb-save.stblog
let k = 0
let k = (length(frequency) eq 31) & (length(loopgain) eq 31) & (vecmax(abs(loopgain + 10/(1 + j(real(frequency)/const.fp)))) < 1e-9)
if k
  echo stbchk save-dot-save pass
else
  echo stbchk save-dot-save fail
end

* ac: the scale and v(out), nothing else
ac dec 5 1 1e6
display > stb-save.stblog
let const.nvec = 0
let const.nout = 0
set n1 = 1
fopen f1 stb-save.stblog r
while $n1 >= 0
  set ln = "none"
  fread ln $f1 n1
  strstr p1 "_$ln" " long"
  if $p1 >= 0
    let const.nvec = const.nvec + 1
    strstr p2 "_$ln" " out "
    if $p2 >= 0
      let const.nout = const.nout + 1
    end
  end
end
fclose $f1
if (const.nvec eq 2) & (const.nout eq 1)
  echo stbchk save-ac-obeys pass
else
  echo stbchk save-ac-obeys fail
end

* a save of a device parameter
save @r1[i]
stb vprb dec 5 1 1e6 > stb-save.stblog
let k = 0
let k = (length(frequency) eq 31) & (length(loopgain) eq 31) & (vecmax(abs(loopgain + 10/(1 + j(real(frequency)/const.fp)))) < 1e-9)
if k
  echo stbchk save-device-parameter pass
else
  echo stbchk save-device-parameter fail
end

* save none
save none
set sp0 = $curplot
stb vprb dec 5 1 1e6 > stb-save.stblog
strcmp same "$curplot" "$sp0"
let k = 0
let k = (length(frequency) eq 31) & (length(loopgain) eq 31) & (vecmax(abs(loopgain + 10/(1 + j(real(frequency)/const.fp)))) < 1e-9)
if k & ($same ne 0)
  echo stbchk save-none pass
else
  echo stbchk save-none fail
end
.endc
.end
