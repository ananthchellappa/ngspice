* stb: a port of x1 is not a port of an x1 inside another subcircuit
*
* The definition of outer has a definition of its own, inner, and an
* instance of it that is also called x1. The deck has two instances of
* outer, x1 and x2. The probe x1:1 names the first port of the x1 of the
* deck: the line "x1 a b inner" inside the definition is another
* instance, x1.x1 or x2.x1, and stays as it is, so x2 is not touched and
* one source is made.
*
* Each outer is 1k from a to b and 1k || 1k from b to ground:
* v(n2) = v(n3) = 1/3 V, and 2/3 mA flows into each. The source at x1:1
* has all the current into x1, from its negative to its positive node.
.subckt outer a b
.subckt inner p q
r1 p q 1k
r2 q 0 1k
.ends
x1 a b inner
rb b 0 1k
.ends
x1 n1 n2 outer
x2 n1 n3 outer
v1 n1 0 1
.control
if 0
  stb x1:1 dec 5 1 1e6
end
op
print all
let k = 0
let k = (abs(v(x1#stb1) - 1) < 1e-12) & (abs(v.x1#stb1#branch + 2m/3) < 1e-12) & (abs(v(n2) - 1/3) < 1e-12) & (abs(v(n3) - 1/3) < 1e-12) & (abs(v1#branch + 4m/3) < 1e-12)
if k
  echo stbchk scope-instance-of-the-deck pass
else
  echo stbchk scope-instance-of-the-deck fail
end
.endc
.end
