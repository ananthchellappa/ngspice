r1 a b 1k
*
* stb: a title that reads like an element line is still the title
*
* The first line of this deck is its title. It reads like the line of a
* resistor r1, but the deck has no element r1: the probe r1:1 is not
* inserted, the reader says so, no node and no source are added, and the
* command fails with the same reason. It gives exactly one line starting
* with "Error: stb:", sets sim_status to 1 and adds no plot.
* v(b) = 0.5 V.
v1 a 0 dc 1
r2 a b 1k
rb b 0 1k
.control
if 0
  stb r1:1 dec 5 1 1e6
end
op
print all
let const.k = 0
let const.k = abs(v(b) - 0.5) < 1e-12
set nbefore = $#plots
set cbefore = $curplot
set sim_status = 0
stb r1:1 dec 5 1 1e6 >& term-title-card.stberr
let const.nerr = 0
let const.nline = 0
set n1 = 1
fopen f1 term-title-card.stberr r
while $n1 >= 0
  set ln = "none"
  fread ln $f1 n1
  strcmp p1 "$ln" "Error: stb: probe r1:1: no instance named r1"
  if $p1 eq 0
    let const.nerr = const.nerr + 1
  end
  strstr p2 "_$ln" "Error: stb:"
  if $p2 >= 0
    let const.nline = const.nline + 1
  end
end
fclose $f1
strcmp same "$curplot" "$cbefore"
if const.k & (const.nerr eq 1) & (const.nline eq 1) & ($sim_status eq 1) & ($#plots eq $nbefore) & ($same eq 0)
  echo stbchk title-is-no-element pass
else
  echo stbchk title-is-no-element fail
end
.endc
.end
