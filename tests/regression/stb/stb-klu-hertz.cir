* stb: sources that depend on "hertz", with the KLU solver
*
* The operating point is solved again at each frequency. With KLU the
* matrix goes from its complex form to the real one and back each time,
* and its factors are made anew for each form.
*
* Loop c of stb-sources.cir (nodes hx, hy), a linear loop:
*     loopgain = -(6 + 5 f/1k)
*
* Loop d (nodes p, q, o), where the operating point itself moves with the
* frequency. The probe carries -12 V and bq = -a v(q)^2, a = 1 + hertz/1k,
* so a v(q)^2 + v(q) = 12 and the gain of bq there is -2 a v(q):
*     loopgain = 1 - sqrt(1 + 48 a) = 1 - sqrt(49 + 48 f/1k)
* (-6 at 0 Hz, the loop b of stb-sources.cir; the root that the iteration
* reaches from 0).
*
* An op afterwards still runs (the probe holds its -12 V), and a further
* stb run agrees with the first.
.option klu
.options reltol=1e-9 vntol=1e-12 abstol=1e-15
vh hx hy dc 0
gh hx 0 hy 0 1m
bh hy 0 i = 5m*v(hx)*(1 + hertz/1k)
r4 hx 0 5k
r5 hy 0 1.25k
*
vq p q dc -12
bq o 0 v = -v(q)*v(q)*(1 + hertz/1k)
rq o p 1k
.control
stb vh dec 5 100 1e4 > stb-klu-hertz.stblog
set sp1 = $curplot
let k = 0
let k = (length(loopgain) eq 11) & (vecmax(abs(loopgain + 6 + 5*real(frequency)/1k)/(6 + 5*real(frequency)/1k)) < 1e-9)
if k
  echo stbchk klu-hertz-linear pass
else
  echo stbchk klu-hertz-linear fail
end

stb vq dec 5 100 1e4 > stb-klu-hertz.stblog
let k = 0
let k = (length(loopgain) eq 11) & (vecmax(abs(loopgain - 1 + sqrt(49 + 48*real(frequency)/1k))/sqrt(49 + 48*real(frequency)/1k)) < 1e-9)
if k
  echo stbchk klu-hertz-operating-point pass
else
  echo stbchk klu-hertz-operating-point fail
end

op
let k = 0
let k = abs(v(p) - v(q) + 12) < 1e-9
if k
  echo stbchk klu-hertz-op-after pass
else
  echo stbchk klu-hertz-op-after fail
end

stb vh dec 5 100 1e4 > stb-klu-hertz.stblog
strcmp same "$curplot" "$sp1"
let k = 0
let k = (length(loopgain) eq 11) & (vecmax(abs(loopgain - {$sp1}.loopgain)) < 1e-9)
if k & ($same ne 0)
  echo stbchk klu-hertz-again pass
else
  echo stbchk klu-hertz-again fail
end
.endc
.end
