* the undefined-node report for a B source V() reference, and the silences it owes
* doc/codex/issues/0028 gap 1, in the DEFAULT case mode.
* INPtermCaseCheck() (src/spicelib/parser/inpsymt.c) reports a node that a
* V() reference created and that no card ever defined.  With a name differing
* from it only in case defined it says so and names both spellings, which is
* doc/claude/decisions/0002-deferred-node-resolution-check.md and fires only
* under distinguish; with no such name the report is the plain undefined node
* and is mode independent, which is this deck and
* doc/claude/decisions/0008-undefined-node-diagnostic.md.
*
* This deck is in tests/regression/misc and not in tests/regression/casedist
* because casedist forces -D casemode=distinguish on every deck it holds and
* the report asserted here is the one that fires with no casemode set at all.
* diff-pairing-case.cir is the precedent for a default-mode deck of this
* series here.  Everything below is lower case for the same reason: the
* default reader folds a card, so a mixed-case sub-deck would be asserting
* about the fold rather than about the node.
*
* The diagnostic is written before the first line of any .control block runs -
* it is the end of the parse, src/frontend/spiceif.c - so there is no command
* to attach a redirect to.  This deck therefore writes each circuit out with
* echo and sources it from inside its own control block: 'source' re-enters
* inp_spsource() and if_inpdeck(), so the whole parse including the check runs
* again, with the wrapper's redirect in force.  '>&' sets cp_err as well as
* cp_out (src/frontend/streams.c), and the sourced circuit stays current
* afterwards, which is why the op and the prints below are about the sub-deck.
* bsource-node-case-report.cir is the shape and doc/claude/decisions/
* 0006-diagnostic-deck-coverage.md decision 2 is why it is the only one
* available.  The bun_* names are lower case because in the default mode the
* reader lower cases a control line unless its first word is on a fixed exempt
* list - 'echo' and 'source' are on it, 'fopen' is not - doc/codex/issues/0038.
*
* Every case that asserts a SILENCE also asserts something POSITIVE about the
* same capture, so that the silence cannot pass on a capture that was never
* read, on a sub-deck that was never written, or on the wrong file: the FLOAT
* and FWDREF sub-decks each carry a second, genuinely undefined node whose
* report must appear, so a silence that passes proves the check ran over that
* capture and that the capture is the right one.  Every token is upper case
* because tests/bin/check.sh drops any line containing 'Warning'.
*
*   TYPO     v(mdi) against a net 'mid'   -> reported
*   FLOAT    a net named by exactly one card, which is a legal floating node
*            in SPICE                     -> silent.  This is the case that
*            decides the rule: the bit is set by a REFERENCE, so a node a card
*            names is not a candidate however few cards name it
*   FWDREF   v(mid) referenced before the cards that define it -> silent
*
* One silence this diagnostic owes is NOT here, because this harness cannot
* hold it: when INP2dot() returns 1 - a .dc whose syntax is bad - INPpas2()
* abandons the deck with the cards below that line unparsed, and the nodes
* they define must not be reported.  A sub-deck that does it kills the
* control block that sourced it, so the scan below it never runs.  The
* silence is checked by hand instead and the command is in
* doc/claude/decisions/0008-undefined-node-diagnostic.md decision 7.
.OPTIONS noacct
.control
* --- TYPO: a reference no card ever claims, with no case variant in sight
echo "* TYPO a V() reference that names a node no card defines" > bun_typo.cir
echo ".OPTIONS noacct rshunt=1e9" >> bun_typo.cir
echo "v1 mid 0 dc 1.5" >> bun_typo.cir
echo "r1 mid 0 1k" >> bun_typo.cir
echo "b2 miss 0 V={V(mdi)*2}" >> bun_typo.cir
echo "r3 miss 0 1k" >> bun_typo.cir
echo ".end" >> bun_typo.cir
source bun_typo.cir >& bun_typo.txt
set found1 = 0
set n1 = 1
fopen f1 bun_typo.txt r
while $n1 >= 0
  set capline = "no_line_read"
  fread capline $f1 n1
  strstr p1 "_$capline" "no node named 'mdi'; it is referenced"
  if $p1 >= 0
    set found1 = 1
  end
end
fclose $f1
if $found1 > 0
  echo UNDEF-TYPO-REPORTED
else
  echo UNDEF-TYPO-SILENT
end
op
print v(mid)
print v(miss)
* --- FLOAT: one card names 'dangle' and nothing else does, which is legal.
* --- 'never' in the same sub-deck must be reported, so the silence about
* --- 'dangle' is a silence this run really produced
echo "* FLOAT a legal floating node, named by exactly one card" > bun_float.cir
echo ".OPTIONS noacct rshunt=1e9" >> bun_float.cir
echo "v1 in 0 dc 1.5" >> bun_float.cir
echo "r1 in 0 1k" >> bun_float.cir
echo "r2 in dangle 1k" >> bun_float.cir
echo "b1 out 0 V={V(in)*2}" >> bun_float.cir
echo "r3 out 0 1k" >> bun_float.cir
echo "b3 nope 0 V={V(never)*2}" >> bun_float.cir
echo "r4 nope 0 1k" >> bun_float.cir
echo ".end" >> bun_float.cir
source bun_float.cir >& bun_float.txt
set float2 = 0
set other2 = 0
set n2 = 1
fopen f2 bun_float.txt r
while $n2 >= 0
  set capline = "no_line_read"
  fread capline $f2 n2
  strstr p2 "_$capline" "no node named 'dangle'"
  if $p2 >= 0
    set float2 = 1
  end
  strstr q2 "_$capline" "no node named 'never'; it is referenced"
  if $q2 >= 0
    set other2 = 1
  end
end
fclose $f2
if $float2 > 0
  echo UNDEF-FLOAT-REPORTED
else
  echo UNDEF-FLOAT-SILENT
end
if $other2 > 0
  echo UNDEF-FLOAT-OTHER-REPORTED
else
  echo UNDEF-FLOAT-OTHER-SILENT
end
op
print v(dangle)
print v(out)
* --- FWDREF: the reference creates the node, a later card claims it, and
* --- 'never' again proves the check ran over this sub-deck
echo "* FWDREF a forward reference claimed by a later card" > bun_fwdref.cir
echo ".OPTIONS noacct rshunt=1e9" >> bun_fwdref.cir
echo "b1 out 0 V={V(mid)*2}" >> bun_fwdref.cir
echo "r2 out 0 1k" >> bun_fwdref.cir
echo "b3 nope 0 V={V(never)*2}" >> bun_fwdref.cir
echo "r4 nope 0 1k" >> bun_fwdref.cir
echo "v1 mid 0 dc 1.5" >> bun_fwdref.cir
echo "r1 mid 0 1k" >> bun_fwdref.cir
echo ".end" >> bun_fwdref.cir
source bun_fwdref.cir >& bun_fwdref.txt
set fwd3 = 0
set other3 = 0
set n3 = 1
fopen f3 bun_fwdref.txt r
while $n3 >= 0
  set capline = "no_line_read"
  fread capline $f3 n3
  strstr p3 "_$capline" "no node named 'mid'"
  if $p3 >= 0
    set fwd3 = 1
  end
  strstr q3 "_$capline" "no node named 'never'; it is referenced"
  if $q3 >= 0
    set other3 = 1
  end
end
fclose $f3
if $fwd3 > 0
  echo UNDEF-FWDREF-REPORTED
else
  echo UNDEF-FWDREF-SILENT
end
if $other3 > 0
  echo UNDEF-FWDREF-OTHER-REPORTED
else
  echo UNDEF-FWDREF-OTHER-SILENT
end
op
print v(out)
.endc
.end
