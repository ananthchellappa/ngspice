* the undefined-node report for the dot cards that name a node they expect to exist
* doc/codex/issues/0028 gap 2, in the DEFAULT case mode.
* .noise, .tf, .sens and .pz each resolve a node name with a call that creates
* the node on a miss, exactly as a B source V() reference does
* (src/spicelib/parser/inp2dot.c and src/spicelib/parser/inpgval.c).  Each is a
* reference and not a definition, so each takes INPtermInsertRef() and is
* reported by INPtermCaseCheck() when no card ever defines the name.  Before
* that they inserted as definitions, which also CLEARED the bit a V()
* reference had set, so a dot card naming the manufactured node suppressed the
* near-miss warning of doc/claude/decisions/0002; that half is asserted by
* tests/regression/casedist/sens-node-case-report.cir, in the mode it needs.
*
* The MISS case names each card's node in BOTH its forms - v(a) and the two
* node v(a,b) - because they are different call sites: inp2dot.c has one call
* for the output node and a second for the reference node, and only the first
* of each pair is exercised by a v(a) deck.  That is six of the seven sites a
* deck in this build can reach.  The seventh is inpgval.c, whose IF_NODE
* branch .pz is the only reachable producer of: no device or model parameter
* in the tree is IF_NODE typed, and .pz's four nodes are one call site, not
* four.  The two sites no deck here can reach are .pss, behind #ifdef
* WITH_PSS, which bare ../configure leaves undefined, and .hb, behind WITH_HB,
* which no configure.ac or header in the tree ever defines.
*
* The deck shape is bsource-undef-node-report.cir's and the reason for it is
* doc/claude/decisions/0006-diagnostic-deck-coverage.md decision 2: the
* diagnostic is written during the parse, so the only redirect that can reach
* it is one in force across a 'source'.  Tokens are upper case because
* tests/bin/check.sh drops any line containing 'Warning', and the dun_* names
* are lower case because the default reader folds a control line whose first
* word is not on its exempt list (doc/codex/issues/0038).
*
* Each case that asserts a SILENCE also asserts something positive about the
* same capture, so that it cannot pass on a capture that was never read or on
* the wrong sub-deck: OK matches its own title line - the words of it the
* default reader leaves alone, since it lower cases the card - and FWD carries
* one node that IS undefined beside the ones that are merely defined further
* down.
*
*   OK       every dot card names a node a device card defines -> silent
*   FWD      the dot cards come FIRST, before the cards that define the nodes
*            -> silent, which is why the check is deferred to the end of the
*            parse for these sites too and not raised at the card
*   MISS     each dot card names nodes no card defines -> eight reports, each
*            asserted by name, and the near-miss text must NOT appear: these
*            are undefined nodes, not case misses.  No op follows this case:
*            eight manufactured nodes with no DC path make the matrix singular
*            and the solve dies inside spSolve on an unfactored matrix.  That
*            is the second shape of doc/claude/decisions/0002's Context
*            section, and these reports are what now arrive before it
.OPTIONS noacct
.control
* --- OK: the reference resolves because the deck spells it the way it wrote it
echo "* OK dot cards naming nodes the deck defines" > dun_ok.cir
echo ".OPTIONS noacct" >> dun_ok.cir
echo "v1 in 0 dc 1 ac 1" >> dun_ok.cir
echo "r1 in out 1k" >> dun_ok.cir
echo "r2 out 0 1k" >> dun_ok.cir
echo ".noise v(out,in) v1 dec 2 1k 10k" >> dun_ok.cir
echo ".tf v(out,in) v1" >> dun_ok.cir
echo ".sens v(out,in)" >> dun_ok.cir
echo ".pz in 0 out 0 vol pz" >> dun_ok.cir
echo ".end" >> dun_ok.cir
source dun_ok.cir >& dun_ok.txt
set found1 = 0
set read1 = 0
set n1 = 1
fopen f1 dun_ok.txt r
while $n1 >= 0
  set capline = "no_line_read"
  fread capline $f1 n1
  strstr p1 "_$capline" "no node named"
  if $p1 >= 0
    set found1 = 1
  end
  strstr r1 "_$capline" "dot cards naming nodes the deck defines"
  if $r1 >= 0
    set read1 = 1
  end
end
fclose $f1
if $found1 > 0
  echo DOTCARD-OK-REPORTED
else
  echo DOTCARD-OK-SILENT
end
if $read1 > 0
  echo DOTCARD-OK-CAPTURE-READ
else
  echo DOTCARD-OK-CAPTURE-EMPTY
end
op
print v(out)
* --- FWD: the dot cards are parsed before the cards that define their nodes.
* --- 'fwdmiss' is named by a dot card and by nothing else, so its report
* --- proves these cards were parsed and the check did run over them
echo "* FWD dot cards ahead of the cards that define the nodes they name" > dun_fwd.cir
echo ".OPTIONS noacct" >> dun_fwd.cir
echo ".noise v(out) v1 dec 2 1k 10k" >> dun_fwd.cir
echo ".tf v(out) v1" >> dun_fwd.cir
echo ".sens v(fwdmiss)" >> dun_fwd.cir
echo ".pz in 0 out 0 vol pz" >> dun_fwd.cir
echo "v1 in 0 dc 1 ac 1" >> dun_fwd.cir
echo "r1 in out 1k" >> dun_fwd.cir
echo "r2 out 0 1k" >> dun_fwd.cir
echo ".end" >> dun_fwd.cir
source dun_fwd.cir >& dun_fwd.txt
set fwd2 = 0
set other2 = 0
set n2 = 1
fopen f2 dun_fwd.txt r
while $n2 >= 0
  set capline = "no_line_read"
  fread capline $f2 n2
  strstr p2 "_$capline" "no node named 'out'"
  if $p2 >= 0
    set fwd2 = 1
  end
  strstr q2 "_$capline" "no node named 'fwdmiss'; it is referenced"
  if $q2 >= 0
    set other2 = 1
  end
end
fclose $f2
if $fwd2 > 0
  echo DOTCARD-FWD-REPORTED
else
  echo DOTCARD-FWD-SILENT
end
if $other2 > 0
  echo DOTCARD-FWD-OTHER-REPORTED
else
  echo DOTCARD-FWD-OTHER-SILENT
end
op
print v(out)
* --- MISS: two typos per card, one for each of its two call sites
echo "* MISS dot cards naming nodes no card defines" > dun_miss.cir
echo ".OPTIONS noacct" >> dun_miss.cir
echo "v1 in 0 dc 1 ac 1" >> dun_miss.cir
echo "r1 in out 1k" >> dun_miss.cir
echo "r2 out 0 1k" >> dun_miss.cir
echo ".noise v(uot,uref) v1 dec 2 1k 10k" >> dun_miss.cir
echo ".tf v(tuo,tneg) v1" >> dun_miss.cir
echo ".sens v(sou,sneg)" >> dun_miss.cir
echo ".pz zin 0 zut 0 vol pz" >> dun_miss.cir
echo ".end" >> dun_miss.cir
source dun_miss.cir >& dun_miss.txt
set noise3 = 0
set noiseref3 = 0
set tf3 = 0
set tfneg3 = 0
set sens3 = 0
set sensneg3 = 0
set pzi3 = 0
set pzj3 = 0
set near3 = 0
set n3 = 1
fopen f3 dun_miss.txt r
while $n3 >= 0
  set capline = "no_line_read"
  fread capline $f3 n3
  strstr a3 "_$capline" "no node named 'uot'; it is referenced"
  if $a3 >= 0
    set noise3 = 1
  end
  strstr b3 "_$capline" "no node named 'uref'; it is referenced"
  if $b3 >= 0
    set noiseref3 = 1
  end
  strstr c3 "_$capline" "no node named 'tuo'; it is referenced"
  if $c3 >= 0
    set tf3 = 1
  end
  strstr d3 "_$capline" "no node named 'tneg'; it is referenced"
  if $d3 >= 0
    set tfneg3 = 1
  end
  strstr e3 "_$capline" "no node named 'sou'; it is referenced"
  if $e3 >= 0
    set sens3 = 1
  end
  strstr g3 "_$capline" "no node named 'sneg'; it is referenced"
  if $g3 >= 0
    set sensneg3 = 1
  end
  strstr h3 "_$capline" "no node named 'zin'; it is referenced"
  if $h3 >= 0
    set pzi3 = 1
  end
  strstr i3 "_$capline" "no node named 'zut'; it is referenced"
  if $i3 >= 0
    set pzj3 = 1
  end
  strstr j3 "_$capline" "differs only in case"
  if $j3 >= 0
    set near3 = 1
  end
end
fclose $f3
if $noise3 > 0
  echo NOISE-OUT-MISS-REPORTED
else
  echo NOISE-OUT-MISS-SILENT
end
if $noiseref3 > 0
  echo NOISE-REF-MISS-REPORTED
else
  echo NOISE-REF-MISS-SILENT
end
if $tf3 > 0
  echo TF-POS-MISS-REPORTED
else
  echo TF-POS-MISS-SILENT
end
if $tfneg3 > 0
  echo TF-NEG-MISS-REPORTED
else
  echo TF-NEG-MISS-SILENT
end
if $sens3 > 0
  echo SENS-POS-MISS-REPORTED
else
  echo SENS-POS-MISS-SILENT
end
if $sensneg3 > 0
  echo SENS-NEG-MISS-REPORTED
else
  echo SENS-NEG-MISS-SILENT
end
if $pzi3 > 0
  echo PZ-FIRST-MISS-REPORTED
else
  echo PZ-FIRST-MISS-SILENT
end
if $pzj3 > 0
  echo PZ-THIRD-MISS-REPORTED
else
  echo PZ-THIRD-MISS-SILENT
end
if $near3 > 0
  echo DOTCARD-MISS-NEARMISS
else
  echo DOTCARD-MISS-NOT-NEARMISS
end
* Batch mode runs the analyses of whichever circuit is current when this block
* ends, and every sub-deck above carries four of them: the MISS one would die
* in spSolve on the unfactored matrix its eight DC-pathless nodes produce,
* taking the whole deck with it - and a deck that dies produces no stdout at
* all, which is indistinguishable from a pass against an empty reference,
* which is how this was found.  So the last thing sourced is a circuit with no
* analysis in it, and the op and print below are what say that source worked:
* point it at a name that does not exist and the MISS circuit is still current
* here, so the op dies and the deck fails loudly rather than quietly losing
* its guard.  'remcirc' would be the obvious way to do this and is not used:
* with a rawfile requested, as doc/claude/scripts/case_differential_sweep.py
* requests one, it segfaults on this tree, doc/codex/issues/0042.  The plots
* are then destroyed so that no rawfile is written from them: the sweep's
* uppercased copy of this deck cannot write one - it sources a name its own
* echo line uppercased - and a rawfile on one side only is the sweep's
* NUM-DIFF verdict, which exists to mean a number moved.
echo "* END a circuit with no analysis in it" > dun_end.cir
echo ".OPTIONS noacct" >> dun_end.cir
echo "v9 tail 0 dc 1" >> dun_end.cir
echo "r9 tail 0 1k" >> dun_end.cir
echo ".end" >> dun_end.cir
source dun_end.cir
op
print v(tail)
destroy all
.endc
.end
