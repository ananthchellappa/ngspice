* setseed 7 draws what ngspice-45.2 draws
* A guard, green before and after ver_51 batch item 3: removing the process-id
* seeding from initw() must not touch com_sseed() or TausSeed(), so an
* explicit 'setseed 7' still gives @r1[r] = 9.068279585256480e+02, the value
* ngspice-45.2 gives.  That value comes from glibc's rand(), so this deck is
* Linux-only (glibc); on another libc it fails without anything being wrong.
* The tolerance is 1e-9 ohm, about 1e-12 relative, while a different seed
* moves the draw by tens of ohms.
.param rv=agauss(1k,100,1)
v1 1 0 1
r1 1 0 {rv}
.control
set numdgt=15
setseed 7
reset
op
print @r1[r]
let const.err = abs(@r1[r] - 9.068279585256480e+02)
if const.err < 1e-9
  echo setseed7-bit-identity: setseed 7 draws the 45.2 value
  quit 0
end
echo setseed7-bit-identity: setseed 7 no longer draws the 45.2 value
quit 1
.endc
.end
