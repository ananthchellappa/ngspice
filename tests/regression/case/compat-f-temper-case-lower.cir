* lower case twin of compat-f-temper-case.cir
.OPTIONS noacct
.options temp=75
v1 1 0 dc 1
r1 1 2 1k
vm 2 0 dc 0
f1 3 0 vm {2*(temper-27)}
r2 3 0 1k
.control
op
print v(3)
.endc
.end
