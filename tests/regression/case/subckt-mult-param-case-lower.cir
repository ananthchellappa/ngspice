* lower case twin of subckt-mult-param-case.cir
.OPTIONS noacct
V1 1 0 dc 2
X1 1 2 divider m=2
X2 1 3 divider m=2
X3 1 4 divider m = 2
R11 2 0 1k
R12 3 0 1k
R13 4 0 1k
.subckt divider a b
V2 a c dc 0
R2 c b 1k
.ends
.control
op
print v(2) v(3) v(4)
.endc
.end
