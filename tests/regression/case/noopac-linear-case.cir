* upper case R/C/V deck misclassified as non-linear, under casemode=preserve
* cktislinear() switches on a card's first byte against lower case letters
* only:
*     firstchar = *dd->line;
*     switch (firstchar) { case 'r': case 'l': case 'c': ...
* so under preserve an upper case R, L, C, I or V card takes the default arm
* and clears ckt->CKTisLinear on the very first device card.  cktdojob.c:109
* then computes CKTnoopac = TSKnoopac && CKTisLinear, so '.options noopac'
* silently stops working and acan.c:133 runs CKTop() after all.
* The flag has exactly one consumer, and the line acan.c:146 prints when it
* fires — " Linear circuit, option noopac given: no OP analysis" — contains
* "nalysis" and is deleted by tests/bin/check.sh's filter.  'keepopinfo' is
* what turns the flag into a number: acan.c dumps the AC operating point
* plot whether or not CKTop ran, so a skipped OP leaves it at the zeroed
* CKTrhsOld while a computed one carries the real divider voltage
* 1 V * 2k/3k = 6.666667e-01.
* 'setplot previous' rather than 'setplot op1', and no control-language
* function in the printed expression: the differential sweep uppercases the
* whole deck for its third run, and neither SETPLOT OP1 nor MAG(V(2))
* resolves under preserve -- the plot name is generated in lower case and the
* function name keeps its case in the printed label.  Written this way the
* uppercased copy prints the same text and the pair costs the sweep nothing.
* doc/codex/issues/0019; src/frontend/inp.c:2030.
.OPTIONS noacct noopac keepopinfo
V1 1 0 dc 1 ac 1
R1 1 2 1k
R2 2 0 2k
C1 2 0 1u
.control
ac lin 1 1k 1k
setplot previous
print v(2)
.endc
.end
