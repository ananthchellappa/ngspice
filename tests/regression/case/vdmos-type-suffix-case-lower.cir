* lower case twin of vdmos-type-suffix-case.cir
.OPTIONS noacct
v1 1 0 dc -5
v2 2 0 dc -5
r1 1 3 1k
m1 3 2 0 pmodv
.model pmodv vdmosp vto=-1 kp=1
.control
op
print v(3)
.endc
.end
