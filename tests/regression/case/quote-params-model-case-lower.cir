* lower case twin of quote-params-model-case.cir
.OPTIONS noacct
.param nmod=7
v1 1 0 dc 5
v2 3 0 dc 5
r1 1 2 10k
m1 2 3 0 0 nmod
.model nmod nmos level=1 vto=1 kp=2e-5
.control
op
print v(2)
.endc
.end
