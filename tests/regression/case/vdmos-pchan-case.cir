* 'PCHAN' on a VDMOS .model card, under casemode=preserve
* inp_vdmos_model() decides the channel type of a VDMOS with
* search_plain_identifier(cut_line, "pchan").  That search hit with strstr
* against a lower-case literal, so 'PCHAN' selected an n-channel device and
* the operating point silently moved:
*   v(3) = -6.92888e-01   instead of   v(3) = -1.24988e-03
* This is the shape doc/codex/issues/0013 warns about and the only one in
* this directory that produces a wrong number rather than a diagnostic, so
* it is the one tests/bin/check.sh could have caught unaided -- its filter
* removes 'Error' and 'Warning' from both sides of the comparison.
.OPTIONS noacct
V1 1 0 dc -5
V2 2 0 dc -5
R1 1 3 1k
M1 3 2 0 pmodv
.model pmodv VDMOS PCHAN vto=-1 kp=1
.control
op
print v(3)
.endc
.end
