* 'VDMOSP' as the model type token, under casemode=preserve
* inp_vdmos_model() rewrites a VDMOS .model card into vdmosn or vdmosp.  It
* recognises the type token case-insensitively with cieqn(cut_line, "vdmos",
* 5) and then decided the channel with two tests: the "pchan" keyword search
* doc/codex/issues/0013 folded, and cut_line[5] == 'p', which was not folded.
* So '.model pmodv VDMOSP' matched as a VDMOS, missed the 'p', and became an
* n-channel device.  Like vdmos-pchan-case.cir this is a wrong number, not a
* diagnostic:
*   v(3) = -6.92888e-01   instead of   v(3) = -1.24988e-03
* doc/codex/issues/0009 follow-up table, group D, inpcom.c:8844.
.OPTIONS noacct
V1 1 0 dc -5
V2 2 0 dc -5
R1 1 3 1k
M1 3 2 0 pmodv
.model pmodv VDMOSP vto=-1 kp=1
.control
op
print v(3)
.endc
.end
