* lower case twin of func-formal-case.cir
.OPTIONS noacct
.func dbl(xx) {2*xx}
V1 1 0 dc 4
R1 1 2 {dbl(500)}
R2 2 0 3k
.control
op
print v(2)
.endc
.end
