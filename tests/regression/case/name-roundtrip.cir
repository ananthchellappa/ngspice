* name round trip under casemode=preserve
* Identifiers are mixed case; the electrical answer is a plain 2:1 divider
* and is identical under every case mode, so the only variable under test is
* the spelling that comes back out.  Ground is node 0 rather than GND
* because the gnd->0 rewrite is a separate, reserved-word question.
*
* 'show' reads the stored instance name, 'display' lists the stored vector
* names, and 'print' goes through vec_basename().  The three are separate
* surfaces and all three must agree, which is the whole point: preserve is
* worthless if the spelling reaches one command and not the next.
.OPTIONS noacct
V1 InA 0 dc 1.5
Rser InA OutB 1k
Rload OutB 0 1k
.control
op
show Rser
display
print v(OutB)
.endc
.end
