* lower case twin of alter-rebin-param-case.cir
* Byte identical to alter-rebin-param-case.cir except that the two parameter
* letters typed at the alter commands are lower case.  Everything else,
* including the instance card's 'W=1u L=1u', is unchanged, because the typed
* parameter letter is the only thing under test here.  Its .out is identical.
*
* This half already re-bins correctly today, so it is the deck that says what
* the answer is; the upper case twin is the one that is wrong before the fix.
*
* doc/codex/issues/0026
.OPTIONS noacct
Vd 1 0 dc 1.5
Vg 2 0 dc 1.5
Rd 1 3 10k
M1 3 2 0 0 nch W=1u L=1u
.model nch.1 nmos level=49 version=3.3.0 lmin=0.1u lmax=2u wmin=0.5u wmax=1.5u vth0=0.4 u0=300
.model nch.2 nmos level=49 version=3.3.0 lmin=0.1u lmax=2u wmin=1.5u wmax=5u vth0=0.9 u0=300
.control
op
print v(3)
alter M1 w=2u
op
print v(3)
alter M1 l=1.5u
op
print v(3)
.endc
.end
