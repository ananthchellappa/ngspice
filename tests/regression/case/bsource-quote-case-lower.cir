* lower case twin of bsource-quote-case.cir
.OPTIONS noacct
v1 1 0 dc 2
b1 2 0 v = v(1) * 3
r1 2 0 1k
.control
op
print v(2)
.endc
.end
