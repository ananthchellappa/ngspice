* alter of an upper case MOS must still re-select the model bin
* com_alter_common() re-selects the binned model after a geometry change
* only when the typed device name starts with a lower case 'm'
* (src/frontend/device.c:1489).  device.c:1420 folds the typed name only
* under inp_case_folding(), which is correct -- folding it under
* casemode=preserve would make every deck-cased name unreachable -- and is
* exactly what leaves the upper case M visible at :1489.
*
* This is the one site in doc/codex/issues/0016 that changes a number with
* no diagnostic at all.  nch.1 and nch.2 differ only in vth0 and in which
* width band they claim, so crossing the bin boundary is visible as a drain
* voltage:
*
*   op            W=1u, bin nch.1, vth0=0.4     v(3) = 1.432887e+00
*   alter M1 w=2u W=2u, bin nch.2, vth0=0.9     v(3) = 1.481980e+00
*
* Without the re-bin the device keeps nch.1's vth0=0.4 at the new width,
* draws more current and lands on 1.340324e+00 instead, so the second
* voltage is the whole assertion.
*
* alter-rebin-case-lower.cir is the all-lower-case twin and its .out is
* byte identical.
*
* doc/codex/issues/0016
.OPTIONS noacct
Vd 1 0 dc 1.5
Vg 2 0 dc 1.5
Rd 1 3 10k
M1 3 2 0 0 nch W=1u L=1u
.model nch.1 nmos level=49 version=3.3.0 lmin=0.1u lmax=2u wmin=0.5u wmax=1.5u vth0=0.4 u0=300
.model nch.2 nmos level=49 version=3.3.0 lmin=0.1u lmax=2u wmin=1.5u wmax=5u vth0=0.9 u0=300
.control
op
print v(3)
alter M1 w=2u
op
print v(3)
.endc
.end
