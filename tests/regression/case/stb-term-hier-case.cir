* stb under casemode=preserve: terminal probes down the hierarchy, by letter
*
* Loops told apart by their gain A; loopgain = -A / (1 + j f/fp),
* fp = 1/(2 pi 1k 1u):
*   X4    Pass hands its ports on to its child XL, an instance of Leaf;
*         both ports of X4 on the net Fb, 20k to ground there: A = 20.
*         The probe is the port T of the child, X4.XL:T
*   X6    the same with 5k: A = 5. The probe is the controlling input
*         of G1 inside the child, X6.XL.G1:3, which is G.X6.XL.G1 in the
*         circuit
*   M1    a transistor with a resistor from its drain to its gate. The
*         probe is its gate, by the letter g or by its position 2
*
* Under preserve two spellings of one name are one name: the parts of a
* path, the name an element has in the circuit, the name of a port. The
* letter of a terminal is a word of the language and is taken in any
* case in every mode. So each of the three terminals gets one source
* however it is spelled, named after the instance as the deck spells it;
* the lines "stb: probe ... inserted as ..." of the expected output show
* them.
*
* Refused when the netlist is read, in the spelling of the probe:
*   X9:sup      the port SUP of Buf is the global node Sup
*   x8.r1:1     R1 of X8 has a behavioural value: the reader has put a B
*               source in its place
*   X8.e1:3     E1 of X8 has an expression
.subckt Leaf T U
G1 a 0 T 0 1m
R1 a 0 1k
C1 a 0 1u
G2 0 U a 0 1m
.ends
.subckt Pass I O
XL I O Leaf
.ends
X4 Fb Fb Pass
Rf Fb 0 20k
X6 Fc Fc Pass
Rh Fc 0 5k
Vdd Vdd 0 3
Rd Vdd D 10k
M1 D Gg 0 0 Nm w=10u l=1u
Rf2 D Gg 1meg
Rg2 Gg 0 2meg
.model Nm nmos level=1 vto=0.5 kp=100u
.global Sup
.subckt Buf In SUP
Rb In SUP 1k
.ends
X9 n9 Sup Buf
Vs Sup 0 1
R9 n9 0 1k
.subckt Beh A B
R1 A B r='1k*(1+v(A)*0)'
E1 q 0 vol='v(A)*2'
Rq q 0 1k
.ends
X8 n8 0 Beh
V8 n8 0 1
.control
let const.fp = 1/(2*pi*1k*1u)

set sp0 = $curplot
stb X4.XL:T dec 2 1 1e4 > stb-term-hier-case.stblog
strcmp same "$curplot" "$sp0"
let k = 0
let k = (length(loopgain) eq 9) & (vecmax(abs(loopgain + 20/(1 + j(real(frequency)/const.fp)))) < 1e-9)
if k & ($same ne 0)
  echo stbchk preserve-child-port-as-written pass
else
  echo stbchk preserve-child-port-as-written fail
end

set sp0 = $curplot
stb x4.xl:t dec 2 1 1e4 > stb-term-hier-case.stblog
strcmp same "$curplot" "$sp0"
let k = 0
let k = (length(loopgain) eq 9) & (vecmax(abs(loopgain + 20/(1 + j(real(frequency)/const.fp)))) < 1e-9)
if k & ($same ne 0)
  echo stbchk preserve-child-port-lower pass
else
  echo stbchk preserve-child-port-lower fail
end

set sp0 = $curplot
stb X4.xl:1 dec 2 1 1e4 > stb-term-hier-case.stblog
strcmp same "$curplot" "$sp0"
let k = 0
let k = (length(loopgain) eq 9) & (vecmax(abs(loopgain + 20/(1 + j(real(frequency)/const.fp)))) < 1e-9)
if k & ($same ne 0)
  echo stbchk preserve-child-port-by-position pass
else
  echo stbchk preserve-child-port-by-position fail
end

set sp0 = $curplot
stb X6.XL.G1:3 dec 2 1 1e4 > stb-term-hier-case.stblog
strcmp same "$curplot" "$sp0"
let k = 0
let k = (length(loopgain) eq 9) & (vecmax(abs(loopgain + 5/(1 + j(real(frequency)/const.fp)))) < 1e-9)
if k & ($same ne 0)
  echo stbchk preserve-element-path-as-written pass
else
  echo stbchk preserve-element-path-as-written fail
end

set sp0 = $curplot
stb x6.xl.g1:3 dec 2 1 1e4 > stb-term-hier-case.stblog
strcmp same "$curplot" "$sp0"
let k = 0
let k = (length(loopgain) eq 9) & (vecmax(abs(loopgain + 5/(1 + j(real(frequency)/const.fp)))) < 1e-9)
if k & ($same ne 0)
  echo stbchk preserve-element-path-lower pass
else
  echo stbchk preserve-element-path-lower fail
end

set sp0 = $curplot
stb g.x6.xl.g1:3 dec 2 1 1e4 > stb-term-hier-case.stblog
strcmp same "$curplot" "$sp0"
let k = 0
let k = (length(loopgain) eq 9) & (vecmax(abs(loopgain + 5/(1 + j(real(frequency)/const.fp)))) < 1e-9)
if k & ($same ne 0)
  echo stbchk preserve-element-flat-name-lower pass
else
  echo stbchk preserve-element-flat-name-lower fail
end

* a spelling that the reader has not seen: the word reaches the command
* through a variable
setcs pv = "x4.Xl:T"
set sp0 = $curplot
stb $pv dec 2 1 1e4 > stb-term-hier-case.stblog
strcmp same "$curplot" "$sp0"
let k = 0
let k = (length(loopgain) eq 9) & (vecmax(abs(loopgain + 20/(1 + j(real(frequency)/const.fp)))) < 1e-9)
if k & ($same ne 0)
  echo stbchk preserve-spelling-not-read pass
else
  echo stbchk preserve-spelling-not-read fail
end

* the gate by its letter, in both cases, and by its position
stb M1:G dec 2 1 1e4 > stb-term-hier-case.stblog
set first = $curplot
let k = 0
let k = (length(loopgain) eq 9) & (abs(loopgain[0]) > 0.1)
if k
  echo stbchk preserve-letter-upper pass
else
  echo stbchk preserve-letter-upper fail
end

set sp0 = $curplot
stb m1:g dec 2 1 1e4 > stb-term-hier-case.stblog
strcmp same "$curplot" "$sp0"
let k = 0
let k = (length(loopgain) eq 9) & (vecmax(abs(loopgain - {$first}.loopgain)) < 1e-12)
if k & ($same ne 0)
  echo stbchk preserve-letter-lower-other-instance-spelling pass
else
  echo stbchk preserve-letter-lower-other-instance-spelling fail
end

set sp0 = $curplot
stb M1:2 dec 2 1 1e4 > stb-term-hier-case.stblog
strcmp same "$curplot" "$sp0"
let k = 0
let k = (length(loopgain) eq 9) & (vecmax(abs(loopgain - {$first}.loopgain)) < 1e-12)
if k & ($same ne 0)
  echo stbchk preserve-letter-position pass
else
  echo stbchk preserve-letter-position fail
end

* one terminal, one probe
op
let k = 0
let k = (abs(v(X4.XL#stb1) - v(Fb)) < 1e-12) & (abs(v(G.X6.XL.G1#stb3) - v(Fc)) < 1e-12) & (abs(v(M1#stb2) - v(Gg)) < 1e-12) & (abs(v.M1#stb2#branch) < 1e-15)
if k
  echo stbchk preserve-one-source-each pass
else
  echo stbchk preserve-one-source-each fail
end

let n0 = 1
let n0 = 0 * length(v(X4.XL#stb1_2))
let n1 = 1
let n1 = 0 * length(v(G.X6.XL.G1#stb3_2))
let n2 = 1
let n2 = 0 * length(v(M1#stb2_2))
let n3 = 1
let n3 = 0 * length(v(X6.XL#stb1))
let n4 = 1
let n4 = 0 * length(v(X9#stb2))
let n5 = 1
let n5 = 0 * length(v(R.X8.R1#stb1))
let n6 = 1
let n6 = 0 * length(v(E.X8.E1#stb3))
if n0 & n1 & n2 & n3 & n4 & n5 & n6
  echo stbchk preserve-no-second-source pass
else
  echo stbchk preserve-no-second-source fail
end

set nbefore = $#plots
set sp0 = $curplot
set sim_status = 0
stb X9:sup dec 2 1 1e4 >& stb-term-hier-case.stberr
strcmp same "$curplot" "$sp0"
if ($#plots eq $nbefore) & ($same eq 0) & ($sim_status eq 1)
  echo stbchk preserve-global-port-refused pass
else
  echo stbchk preserve-global-port-refused fail
end

set nbefore = $#plots
set sp0 = $curplot
set sim_status = 0
stb x8.r1:1 dec 2 1 1e4 >& stb-term-hier-case.stberr
strcmp same "$curplot" "$sp0"
if ($#plots eq $nbefore) & ($same eq 0) & ($sim_status eq 1)
  echo stbchk preserve-behavioural-value-refused pass
else
  echo stbchk preserve-behavioural-value-refused fail
end

set nbefore = $#plots
set sp0 = $curplot
set sim_status = 0
stb X8.e1:3 dec 2 1 1e4 >& stb-term-hier-case.stberr
strcmp same "$curplot" "$sp0"
if ($#plots eq $nbefore) & ($same eq 0) & ($sim_status eq 1)
  echo stbchk preserve-expression-source-refused pass
else
  echo stbchk preserve-expression-source-refused fail
end

* the verdicts are out: do not end the batch run as one that has failed
set sim_status = 0
.endc
.end
