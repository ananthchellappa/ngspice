* lower case twin of vdmos-thermal-nodes-case.cir
.OPTIONS noacct
v1 1 0 dc 5
v2 2 0 dc 5
r1 1 3 1k
m1 3 2 0 4 nmodv thermal
.model nmodv vdmos (vto=1 kp=1 rthjc=1)
.control
op
print v(3)
.endc
.end
