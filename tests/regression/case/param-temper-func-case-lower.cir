* lower case twin of param-temper-func-case.cir
.OPTIONS noacct
.param tcorr={temper+25}
V1 1 0 dc 4
R1 1 2 {tcorr*10}
R2 2 0 3k
.control
op
print v(2)
.endc
.end
