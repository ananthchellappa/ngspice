* lower case twin of compat-g-value-case.cir
.OPTIONS noacct
v1 1 0 dc 2
g1 2 0 value={v(1)*1m}
r1 2 0 1k
.control
op
print v(2)
.endc
.end
