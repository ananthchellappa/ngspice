* upper case device letters under casemode=preserve
* Every device letter here is upper case, which is the ordinary SPICE house
* style.  Everything else -- model names, the subcircuit name, the node names
* -- is lower case or numeric, because model and subcircuit name lookup is
* still strcmp and is a separate question (doc/codex/issues/0010).  So the
* only variable under test is the case of the leading device letter.
*
* Four witnesses, one per preprocessing path that classifies a card by that
* letter:
*   v(2)  R3 carries a semiconductor .model, so get_number_terminals() must
*         recognise 'R' or rem_unused_xxx() comments '.model rmod' out and
*         the card fails with "unknown parameter (rmod)".
*   v(4)  D1 likewise, via the 'd' arm.
*   v(7)  Q1 likewise, via the 'q' arm.
*   v(9)  X1 must be seen as a subcircuit call, or the .subckt body is
*         commented out and expansion reports "unknown subckt".
*
* The evidence is four node voltages, not a diagnostic: tests/bin/check.sh
* filters "Error" and "Warning" out of both sides of the comparison.
* device-letter-case-lower.cir is the all-lower-case twin and its .out is
* identical, which is the actual assertion.
.OPTIONS noacct
V1 1 0 dc 5
R3 1 2 rmod l=12u w=4u
R9 2 0 5k
V2 3 0 dc 5
R4 3 4 10k
D1 4 0 dmod
V3 5 0 dc 5
R5 5 6 1meg
R7 5 7 1k
Q1 7 6 0 qmod
V4 8 0 dc 4
X1 8 9 divider
.model rmod r rsh=1000 narrow=1u
.model dmod d is=1e-14
.model qmod npn bf=100
.subckt divider a b
Ra a b 1k
Rb b 0 3k
.ends
.control
op
print v(2) v(4) v(7) v(9)
.endc
.end
