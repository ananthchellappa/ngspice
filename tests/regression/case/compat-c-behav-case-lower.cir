* lower case twin of compat-c-behav-case.cir
.OPTIONS noacct
v1 1 0 ac 1
r1 1 2 1k
c1 2 0 c={1u*v(3)}
vc 3 0 dc 2
.control
ac lin 1 100 100
print vm(2)
.endc
.end
