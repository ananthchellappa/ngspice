* upper case M= on a subcircuit instance, under casemode=preserve
* inp_fix_inst_calls_for_numparam() gives a subcircuit whose caller passes a
* multiplier an 'm=1' formal parameter, then inp_fix_inst_line() overrides the
* formal's default with the instance's own value by matching the two names
* with
*   if (strcmp(subckt_param_names[i], inst_param_names[j]) == 0)
* The formal is the literal "m" the pass itself appended, so under preserve an
* instance spelling it 'M=' did not match, the default 1 survived, and the
* subcircuit was instantiated once instead of twice.  The deck runs and prints
* the wrong number with nothing on stderr.
* doc/codex/issues/0020 gap 1, inpcom.c:4289.
* The three instances differ only in how the multiplier is spelled; the
* electrical answer is the same for all three, and the 'm=' branch is the one
* that already worked.
.OPTIONS noacct
V1 1 0 dc 2
X1 1 2 divider M=2
X2 1 3 divider m=2
X3 1 4 divider M = 2
R11 2 0 1k
R12 3 0 1k
R13 4 0 1k
.subckt divider a b
V2 a c dc 0
R2 c b 1k
.ends
.control
op
print v(2) v(3) v(4)
.endc
.end
